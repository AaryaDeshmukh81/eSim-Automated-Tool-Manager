* Simple RC Circuit

V1 in 0 DC 5
R1 in out 1k
C1 out 0 1u

.tran 0.1ms 10ms

.control
run
print v(in) v(out)
write test_output.raw v(in) v(out)
.endc

.en
