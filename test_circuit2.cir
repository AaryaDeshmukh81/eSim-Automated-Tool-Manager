* Second Test Circuit

V1 in 0 DC 10
R1 in out 2k
C1 out 0 1u

.tran 0.1ms 10ms
.print tran v(in) v(out)

.end
